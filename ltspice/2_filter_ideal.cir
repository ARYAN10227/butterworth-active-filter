* 4th-order Butterworth LPF, fc = 1 kHz | two unity-gain Sallen-Key stages | IDEAL op-amp (VCVS, gain 1e6)
* Open in LTspice (File > Open, file type *.cir), then Run. Keep tl072.lib in the same folder.
.include tl072.lib
.param R1a=6.81k R2a=36.5k C1a=15n C2a=6.8n
.param R1b=12.1k R2b=43.2k C1b=22n C2b=2.2n
VCC vcc 0 15
VEE vee 0 -15
VIN in 0 AC 1
* Stage A, Q = 0.541 (low-Q stage first)
RA1 in a1 {R1a}
RA2 a1 a2 {R2a}
CA1 a1 mid {C1a}
CA2 a2 0 {C2a}
EUA mid 0 a2 mid 1Meg
* Stage B, Q = 1.307
RB1 mid b1 {R1b}
RB2 b1 b2 {R2b}
CB1 b1 out {C1b}
CB2 b2 0 {C2b}
EUB out 0 b2 out 1Meg
.ac dec 200 10 10Meg
.meas AC f3db WHEN mag(V(out))=0.70711
.meas AC g10k FIND V(out) AT=10k
.meas AC g100k FIND V(out) AT=100k
.meas AC g1meg FIND V(out) AT=1Meg
.end
